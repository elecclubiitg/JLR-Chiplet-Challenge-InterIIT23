# Ansys Electronics Desktop project, version 2023.2
materials:
  Al-Extruded: thermal_conductivity=205 mass_density=2800 specific_heat=900 youngs_modulus=69000000000 poissons_ratio=0.33 thermal_expansion_coefficient=2.277e-06 thermal_material_type=Solid
  air: permittivity=1.0006 permeability=1.0000004 thermal_conductivity=0.0261 mass_density=1.1614 specific_heat=1005 thermal_expansion_coefficient=0.00333 thermal_material_type=Fluid diffusivity=2.88e-05 molecular_mass=0.028966 viscosity=1.84e-05 material_refractive_index=1.000293
  copper: permeability=0.999991 conductivity=58000000 thermal_conductivity=400 mass_density=8933 specific_heat=385 youngs_modulus=120000000000 poissons_ratio=0.38 thermal_expansion_coefficient=1.77e-05
  silicon: permittivity=11.9 thermal_conductivity=148 mass_density=2330 specific_heat=712 youngs_modulus=135000000000 poissons_ratio=0.25 thermal_expansion_coefficient=2.54e-06
  SolderMask: permittivity=3.1 dielectric_loss_tangent=0.035 thermal_conductivity=0.26 mass_density=1570 specific_heat=1140 thermal_expansion_coefficient=6e-05
  silicon_dioxide: permittivity=4 thermal_conductivity=1.5 mass_density=2220 specific_heat=745 thermal_expansion_coefficient=4.5e-06
  gallium_arsenide: permittivity=12.9 thermal_conductivity=46 mass_density=5320 specific_heat=350 youngs_modulus=85500000000 poissons_ratio=0.31 thermal_expansion_coefficient=6.86e-06
  Aluminum 6061-T4: thermal_conductivity=154 mass_density=2700 specific_heat=896 thermal_material_type=Solid
  Epoxy Resin-JSME: thermal_conductivity=0.3 mass_density=1850 specific_heat=1100 thermal_material_type=Solid
surface materials:
  Steel-oxidised-surface: surface_emissivity=0.8

design IcepakDesign1 (Icepak, SteadyState TemperatureAndFlow, model units mm)
options: Default_Fluid_Material=air Default_Solid_Material=Al-Extruded Default_Surface_Material=Steel-oxidised-surface AmbientTemperature=20cel AmbientPressure=0n_per_meter_sq AmbientRadiationTemperature=20cel Gravity_Vector_CS_ID=Global Gravity_Vector_Axis=Z Positive=false Altitude=0meter
geometry:
  Region [air] = region(percentage_offset=50 on all sides)
  Interposer [silicon] = box(corner=(0mm, 0mm, 0.9mm), size=(26mm, 66.64mm, 0.1mm))
  Box2 [silicon] = box(corner=(3mm, 2mm, 1mm), size=(8.66mm, 8.66mm, 1mm))
  Box3 [silicon] = box(corner=(14.34mm, 2mm, 1mm), size=(8.66mm, 8.66mm, 1mm))
  Box4 [silicon] = box(corner=(14.34mm, 12.66mm, 1mm), size=(8.66mm, 8.66mm, 1mm))
  Box5 [silicon] = box(corner=(3mm, 12.66mm, 1mm), size=(8.66mm, 8.66mm, 1mm))
  Box6 [silicon] = box(corner=(1mm, 23.32mm, 1.4mm), size=(11mm, 9mm, 1mm))
  Box7 [silicon] = box(corner=(14mm, 23.32mm, 1.4mm), size=(11mm, 9mm, 1mm))
  Box8 [silicon] = box(corner=(1mm, 34.32mm, 1.4mm), size=(11mm, 9mm, 1mm))
  Box9 [silicon] = box(corner=(14mm, 34.32mm, 1.4mm), size=(11mm, 9mm, 1mm))
  Box10 [silicon] = box(corner=(3mm, 45.32mm, 1mm), size=(8.66mm, 8.66mm, 1mm))
  Box11 [silicon] = box(corner=(14.34mm, 45.32mm, 1mm), size=(8.66mm, 8.66mm, 1mm))
  Box12 [silicon] = box(corner=(3mm, (45.32+8.86+2) mm, 1mm), size=(8.66mm, 8.66mm, 1mm))
  Box13 [silicon] = box(corner=(14.34mm, (45.32+8.86+2) mm, 1mm), size=(8.66mm, 8.66mm, 1mm))
  Box24 [silicon] = box(corner=(3mm, 12.66mm, 1mm), size=(8.66mm, 8.66mm, 1mm))
  Box24.move(0.56907522mm, 0.16498974mm, 2mm)
  Box24.move(10.770925mm, -0.16498974mm, 0mm)
  Box24.move(-11.34mm, -6.9277917e-14mm, -5mm)
  Box24.move(0mm, 4.9737992e-14mm, 5mm)
  Box24.move(5.7731597e-15mm, -10.66mm, 0mm)
  Box24.move(0mm, 3.7303494e-14mm, -0.6mm)
  Box44 [silicon] = box(corner=(3mm, 2mm, 2mm), size=(8.66mm, 8.66mm, 0.4mm))
  Box45 [silicon] = box(corner=(3mm, 2mm, 2mm), size=(8.66mm, 8.66mm, 0.4mm))
  Box46 [silicon] = box(corner=(3mm, 2mm, 2mm), size=(8.66mm, 8.66mm, 0.4mm))
  Box46.move(-4.4408921e-16mm, 10.66mm, 0mm)
  Box47 [silicon] = box(corner=(3mm, 12.66mm, 1mm), size=(8.66mm, 8.66mm, 1mm))
  Box47.move(0.56907522mm, 0.16498974mm, 2mm)
  Box47.move(10.770925mm, -0.16498974mm, 0mm)
  Box47.move(-11.34mm, -6.9277917e-14mm, -5mm)
  Box47.move(0mm, 4.9737992e-14mm, 5mm)
  Box47.move(5.7731597e-15mm, -10.66mm, 0mm)
  Box47.move(0mm, 3.7303494e-14mm, -0.6mm)
  Box47.move(0mm, 10.66mm, 0mm)
  Box48 [silicon] = box(corner=(3mm, 2mm, 2mm), size=(8.66mm, 8.66mm, 0.4mm))
  Box48.move(-4.4408921e-16mm, 10.66mm, 0mm)
  Box48.move(0mm, 3.5527137e-15mm, 1.4mm)
  Box50 [silicon] = box(corner=(3mm, 2mm, 2mm), size=(8.66mm, 8.66mm, 0.4mm))
  Box50.move(-4.4408921e-16mm, 10.66mm, 0mm)
  Box50.move(0mm, 3.5527137e-15mm, 1.4mm)
  Box50.move(0mm, 0mm, 1.4mm)
  Box51 [silicon] = box(corner=(3mm, 12.66mm, 1mm), size=(8.66mm, 8.66mm, 1mm))
  Box51.move(0.56907522mm, 0.16498974mm, 2mm)
  Box51.move(10.770925mm, -0.16498974mm, 0mm)
  Box51.move(-11.34mm, -6.9277917e-14mm, -5mm)
  Box51.move(0mm, 4.9737992e-14mm, 5mm)
  Box51.move(5.7731597e-15mm, -10.66mm, 0mm)
  Box51.move(0mm, 3.7303494e-14mm, -0.6mm)
  Box51.move(0mm, 10.66mm, 0mm)
  Box51.move(0mm, 3.5527137e-15mm, 1.4mm)
  Box51.move(0mm, 0mm, 1.4mm)
  Box52 [silicon] = box(corner=(3mm, 2mm, 2mm), size=(8.66mm, 8.66mm, 0.4mm))
  Box52.move(-4.4408921e-16mm, 10.66mm, 0mm)
  Box52.move(0mm, 3.5527137e-15mm, 1.4mm)
  Box52.move(0mm, -10.66mm, 0mm)
  Box53 [silicon] = box(corner=(3mm, 12.66mm, 1mm), size=(8.66mm, 8.66mm, 1mm))
  Box53.move(0.56907522mm, 0.16498974mm, 2mm)
  Box53.move(10.770925mm, -0.16498974mm, 0mm)
  Box53.move(-11.34mm, -6.9277917e-14mm, -5mm)
  Box53.move(0mm, 4.9737992e-14mm, 5mm)
  Box53.move(5.7731597e-15mm, -10.66mm, 0mm)
  Box53.move(0mm, 3.7303494e-14mm, -0.6mm)
  Box53.move(0mm, 10.66mm, 0mm)
  Box53.move(0mm, 3.5527137e-15mm, 1.4mm)
  Box53.move(0mm, -10.66mm, 0mm)
  Box54 [silicon] = box(corner=(3mm, 2mm, 2mm), size=(8.66mm, 8.66mm, 0.4mm))
  Box54.move(-4.4408921e-16mm, 10.66mm, 0mm)
  Box54.move(0mm, 3.5527137e-15mm, 1.4mm)
  Box54.move(0mm, 0mm, 1.4mm)
  Box54.move(0mm, -10.66mm, 0mm)
  Box55 [silicon] = box(corner=(3mm, 12.66mm, 1mm), size=(8.66mm, 8.66mm, 1mm))
  Box55.move(0.56907522mm, 0.16498974mm, 2mm)
  Box55.move(10.770925mm, -0.16498974mm, 0mm)
  Box55.move(-11.34mm, -6.9277917e-14mm, -5mm)
  Box55.move(0mm, 4.9737992e-14mm, 5mm)
  Box55.move(5.7731597e-15mm, -10.66mm, 0mm)
  Box55.move(0mm, 3.7303494e-14mm, -0.6mm)
  Box55.move(0mm, 10.66mm, 0mm)
  Box55.move(0mm, 3.5527137e-15mm, 1.4mm)
  Box55.move(0mm, 0mm, 1.4mm)
  Box55.move(0mm, -10.66mm, 0mm)
  Box45.move(11.34mm, 4.4408921e-16mm, 0mm)
  Box56 [silicon] = box(corner=(3mm, 12.66mm, 1mm), size=(8.66mm, 8.66mm, 1mm))
  Box56.move(0.56907522mm, 0.16498974mm, 2mm)
  Box56.move(10.770925mm, -0.16498974mm, 0mm)
  Box56.move(-11.34mm, -6.9277917e-14mm, -5mm)
  Box56.move(0mm, 4.9737992e-14mm, 5mm)
  Box56.move(5.7731597e-15mm, -10.66mm, 0mm)
  Box56.move(0mm, 3.7303494e-14mm, -0.6mm)
  Box56.move(11.34mm, -4.4408921e-16mm, 0mm)
  Box57 [silicon] = box(corner=(3mm, 2mm, 2mm), size=(8.66mm, 8.66mm, 0.4mm))
  Box57.move(-4.4408921e-16mm, 10.66mm, 0mm)
  Box57.move(0mm, 3.5527137e-15mm, 1.4mm)
  Box57.move(0mm, -10.66mm, 0mm)
  Box57.move(11.34mm, -1.7763568e-15mm, 0mm)
  Box58 [silicon] = box(corner=(3mm, 12.66mm, 1mm), size=(8.66mm, 8.66mm, 1mm))
  Box58.move(0.56907522mm, 0.16498974mm, 2mm)
  Box58.move(10.770925mm, -0.16498974mm, 0mm)
  Box58.move(-11.34mm, -6.9277917e-14mm, -5mm)
  Box58.move(0mm, 4.9737992e-14mm, 5mm)
  Box58.move(5.7731597e-15mm, -10.66mm, 0mm)
  Box58.move(0mm, 3.7303494e-14mm, -0.6mm)
  Box58.move(0mm, 10.66mm, 0mm)
  Box58.move(0mm, 3.5527137e-15mm, 1.4mm)
  Box58.move(0mm, -10.66mm, 0mm)
  Box58.move(11.34mm, -1.7763568e-15mm, 0mm)
  Box59 [silicon] = box(corner=(3mm, 2mm, 2mm), size=(8.66mm, 8.66mm, 0.4mm))
  Box59.move(-4.4408921e-16mm, 10.66mm, 0mm)
  Box59.move(0mm, 3.5527137e-15mm, 1.4mm)
  Box59.move(0mm, 0mm, 1.4mm)
  Box59.move(0mm, -10.66mm, 0mm)
  Box59.move(11.34mm, 3.9968029e-15mm, 0mm)
  Box60 [silicon] = box(corner=(3mm, 12.66mm, 1mm), size=(8.66mm, 8.66mm, 1mm))
  Box60.move(0.56907522mm, 0.16498974mm, 2mm)
  Box60.move(10.770925mm, -0.16498974mm, 0mm)
  Box60.move(-11.34mm, -6.9277917e-14mm, -5mm)
  Box60.move(0mm, 4.9737992e-14mm, 5mm)
  Box60.move(5.7731597e-15mm, -10.66mm, 0mm)
  Box60.move(0mm, 3.7303494e-14mm, -0.6mm)
  Box60.move(0mm, 10.66mm, 0mm)
  Box60.move(0mm, 3.5527137e-15mm, 1.4mm)
  Box60.move(0mm, 0mm, 1.4mm)
  Box60.move(0mm, -10.66mm, 0mm)
  Box60.move(11.34mm, -1.7763568e-15mm, 0mm)
  Box61 [silicon] = box(corner=(3mm, 2mm, 2mm), size=(8.66mm, 8.66mm, 0.4mm))
  Box61.move(11.34mm, 4.4408921e-16mm, 0mm)
  Box61.move(0mm, 10.66mm, 0mm)
  Box62 [silicon] = box(corner=(3mm, 12.66mm, 1mm), size=(8.66mm, 8.66mm, 1mm))
  Box62.move(0.56907522mm, 0.16498974mm, 2mm)
  Box62.move(10.770925mm, -0.16498974mm, 0mm)
  Box62.move(-11.34mm, -6.9277917e-14mm, -5mm)
  Box62.move(0mm, 4.9737992e-14mm, 5mm)
  Box62.move(5.7731597e-15mm, -10.66mm, 0mm)
  Box62.move(0mm, 3.7303494e-14mm, -0.6mm)
  Box62.move(11.34mm, -4.4408921e-16mm, 0mm)
  Box62.move(0mm, 10.66mm, 0mm)
  Box63 [silicon] = box(corner=(3mm, 2mm, 2mm), size=(8.66mm, 8.66mm, 0.4mm))
  Box63.move(-4.4408921e-16mm, 10.66mm, 0mm)
  Box63.move(0mm, 3.5527137e-15mm, 1.4mm)
  Box63.move(0mm, -10.66mm, 0mm)
  Box63.move(11.34mm, -1.7763568e-15mm, 0mm)
  Box63.move(0mm, 10.66mm, 0mm)
  Box65 [silicon] = box(corner=(3mm, 12.66mm, 1mm), size=(8.66mm, 8.66mm, 1mm))
  Box65.move(0.56907522mm, 0.16498974mm, 2mm)
  Box65.move(10.770925mm, -0.16498974mm, 0mm)
  Box65.move(-11.34mm, -6.9277917e-14mm, -5mm)
  Box65.move(0mm, 4.9737992e-14mm, 5mm)
  Box65.move(5.7731597e-15mm, -10.66mm, 0mm)
  Box65.move(0mm, 3.7303494e-14mm, -0.6mm)
  Box65.move(0mm, 10.66mm, 0mm)
  Box65.move(0mm, 3.5527137e-15mm, 1.4mm)
  Box65.move(0mm, -10.66mm, 0mm)
  Box65.move(11.34mm, -1.7763568e-15mm, 0mm)
  Box65.move(0mm, 10.66mm, 0mm)
  Box66 [silicon] = box(corner=(3mm, 2mm, 2mm), size=(8.66mm, 8.66mm, 0.4mm))
  Box66.move(-4.4408921e-16mm, 10.66mm, 0mm)
  Box66.move(0mm, 3.5527137e-15mm, 1.4mm)
  Box66.move(0mm, 0mm, 1.4mm)
  Box66.move(0mm, -10.66mm, 0mm)
  Box66.move(11.34mm, 3.9968029e-15mm, 0mm)
  Box66.move(-3.5527137e-15mm, 10.66mm, 0mm)
  Box67 [silicon] = box(corner=(3mm, 12.66mm, 1mm), size=(8.66mm, 8.66mm, 1mm))
  Box67.move(0.56907522mm, 0.16498974mm, 2mm)
  Box67.move(10.770925mm, -0.16498974mm, 0mm)
  Box67.move(-11.34mm, -6.9277917e-14mm, -5mm)
  Box67.move(0mm, 4.9737992e-14mm, 5mm)
  Box67.move(5.7731597e-15mm, -10.66mm, 0mm)
  Box67.move(0mm, 3.7303494e-14mm, -0.6mm)
  Box67.move(0mm, 10.66mm, 0mm)
  Box67.move(0mm, 3.5527137e-15mm, 1.4mm)
  Box67.move(0mm, 0mm, 1.4mm)
  Box67.move(0mm, -10.66mm, 0mm)
  Box67.move(11.34mm, -1.7763568e-15mm, 0mm)
  Box67.move(0mm, 10.66mm, 0mm)
  Box68 [silicon] = box(corner=(3mm, 2mm, 2mm), size=(8.66mm, 8.66mm, 0.4mm))
  Box68.move(11.34mm, 4.4408921e-16mm, 0mm)
  Box68.move(0mm, 10.66mm, 0mm)
  Box68.move(0mm, 32.66mm, 0mm)
  Box69 [silicon] = box(corner=(14.34mm, 45.32mm, 1mm), size=(8.66mm, 8.66mm, 1mm))
  Box69.move(-3.5527137e-15mm, 0mm, 1.4mm)
  Box70 [silicon] = box(corner=(3mm, 2mm, 2mm), size=(8.66mm, 8.66mm, 0.4mm))
  Box70.move(11.34mm, 4.4408921e-16mm, 0mm)
  Box70.move(0mm, 10.66mm, 0mm)
  Box70.move(0mm, 32.66mm, 0mm)
  Box70.move(0mm, 7.1054274e-15mm, 1.4mm)
  Box71 [silicon] = box(corner=(14.34mm, 45.32mm, 1mm), size=(8.66mm, 8.66mm, 1mm))
  Box71.move(-3.5527137e-15mm, 0mm, 1.4mm)
  Box71.move(0mm, 0mm, 1.4mm)
  Box72 [silicon] = box(corner=(3mm, 2mm, 2mm), size=(8.66mm, 8.66mm, 0.4mm))
  Box72.move(11.34mm, 4.4408921e-16mm, 0mm)
  Box72.move(0mm, 10.66mm, 0mm)
  Box72.move(0mm, 32.66mm, 0mm)
  Box72.move(0mm, 7.1054274e-15mm, 2.8mm)
  Box73 [silicon] = box(corner=(14.34mm, 45.32mm, 1mm), size=(8.66mm, 8.66mm, 1mm))
  Box73.move(-3.5527137e-15mm, 0mm, 1.4mm)
  Box73.move(0mm, 0mm, 1.4mm)
  Box73.move(0mm, 0mm, 1.4mm)
  Box74 [silicon] = box(corner=(3mm, 2mm, 2mm), size=(8.66mm, 8.66mm, 0.4mm))
  Box74.move(11.34mm, 4.4408921e-16mm, 0mm)
  Box74.move(0mm, 10.66mm, 0mm)
  Box74.move(0mm, 32.66mm, 0mm)
  Box74.move(0mm, 10.86mm, 0mm)
  Box75 [silicon] = box(corner=(14.34mm, 45.32mm, 1mm), size=(8.66mm, 8.66mm, 1mm))
  Box75.move(-3.5527137e-15mm, 0mm, 1.4mm)
  Box75.move(0mm, 10.86mm, 4.4408921e-16mm)
  Box76 [silicon] = box(corner=(3mm, 2mm, 2mm), size=(8.66mm, 8.66mm, 0.4mm))
  Box76.move(11.34mm, 4.4408921e-16mm, 0mm)
  Box76.move(0mm, 10.66mm, 0mm)
  Box76.move(0mm, 32.66mm, 0mm)
  Box76.move(0mm, 7.1054274e-15mm, 1.4mm)
  Box76.move(0mm, 10.86mm, 4.4408921e-16mm)
  Box77 [silicon] = box(corner=(14.34mm, 45.32mm, 1mm), size=(8.66mm, 8.66mm, 1mm))
  Box77.move(-3.5527137e-15mm, 0mm, 1.4mm)
  Box77.move(0mm, 0mm, 1.4mm)
  Box77.move(0mm, 10.86mm, 1.7763568e-15mm)
  Box78 [silicon] = box(corner=(3mm, 2mm, 2mm), size=(8.66mm, 8.66mm, 0.4mm))
  Box78.move(11.34mm, 4.4408921e-16mm, 0mm)
  Box78.move(0mm, 10.66mm, 0mm)
  Box78.move(0mm, 32.66mm, 0mm)
  Box78.move(0mm, 7.1054274e-15mm, 2.8mm)
  Box78.move(0mm, 10.86mm, 2.6645353e-15mm)
  Box79 [silicon] = box(corner=(14.34mm, 45.32mm, 1mm), size=(8.66mm, 8.66mm, 1mm))
  Box79.move(-3.5527137e-15mm, 0mm, 1.4mm)
  Box79.move(0mm, 0mm, 1.4mm)
  Box79.move(0mm, 0mm, 1.4mm)
  Box79.move(0mm, 10.86mm, 3.5527137e-15mm)
  [Box74, Box75, Box76].move(-11.34mm, 0mm, 0mm)
  Box77.move(-11.34mm, 1.4210855e-14mm, -4.4408921e-16mm)
  Box78.move(-11.34mm, 0mm, -8.8817842e-16mm)
  Box79.move(-11.34mm, 1.4210855e-14mm, -8.8817842e-16mm)
  Box80 [silicon] = box(corner=(3mm, 2mm, 2mm), size=(8.66mm, 8.66mm, 0.4mm))
  Box80.move(11.34mm, 4.4408921e-16mm, 0mm)
  Box80.move(0mm, 10.66mm, 0mm)
  Box80.move(0mm, 32.66mm, 0mm)
  Box80.move(0mm, 10.86mm, 0mm)
  Box81 [silicon] = box(corner=(14.34mm, 45.32mm, 1mm), size=(8.66mm, 8.66mm, 1mm))
  Box81.move(-3.5527137e-15mm, 0mm, 1.4mm)
  Box81.move(0mm, 10.86mm, 4.4408921e-16mm)
  Box82 [silicon] = box(corner=(3mm, 2mm, 2mm), size=(8.66mm, 8.66mm, 0.4mm))
  Box82.move(11.34mm, 4.4408921e-16mm, 0mm)
  Box82.move(0mm, 10.66mm, 0mm)
  Box82.move(0mm, 32.66mm, 0mm)
  Box82.move(0mm, 7.1054274e-15mm, 1.4mm)
  Box82.move(0mm, 10.86mm, 4.4408921e-16mm)
  Box83 [silicon] = box(corner=(14.34mm, 45.32mm, 1mm), size=(8.66mm, 8.66mm, 1mm))
  Box83.move(-3.5527137e-15mm, 0mm, 1.4mm)
  Box83.move(0mm, 0mm, 1.4mm)
  Box83.move(0mm, 10.86mm, 1.7763568e-15mm)
  Box84 [silicon] = box(corner=(3mm, 2mm, 2mm), size=(8.66mm, 8.66mm, 0.4mm))
  Box84.move(11.34mm, 4.4408921e-16mm, 0mm)
  Box84.move(0mm, 10.66mm, 0mm)
  Box84.move(0mm, 32.66mm, 0mm)
  Box84.move(0mm, 7.1054274e-15mm, 2.8mm)
  Box84.move(0mm, 10.86mm, 2.6645353e-15mm)
  Box85 [silicon] = box(corner=(14.34mm, 45.32mm, 1mm), size=(8.66mm, 8.66mm, 1mm))
  Box85.move(-3.5527137e-15mm, 0mm, 1.4mm)
  Box85.move(0mm, 0mm, 1.4mm)
  Box85.move(0mm, 0mm, 1.4mm)
  Box85.move(0mm, 10.86mm, 3.5527137e-15mm)
  Box86 [silicon] = box(corner=(3mm, 2mm, 2mm), size=(8.66mm, 8.66mm, 0.4mm))
  Box86.move(11.34mm, 4.4408921e-16mm, 0mm)
  Box86.move(0mm, 10.66mm, 0mm)
  Box86.move(0mm, 32.66mm, 0mm)
  Box86.move(0mm, 10.86mm, 0mm)
  Box86.move(-11.34mm, 0mm, 0mm)
  Box86.move(0mm, -10.86mm, 0mm)
  Box87 [silicon] = box(corner=(14.34mm, 45.32mm, 1mm), size=(8.66mm, 8.66mm, 1mm))
  Box87.move(-3.5527137e-15mm, 0mm, 1.4mm)
  Box87.move(0mm, 10.86mm, 4.4408921e-16mm)
  Box87.move(-11.34mm, 0mm, 0mm)
  Box87.move(0mm, -10.86mm, 0mm)
  Box88 [silicon] = box(corner=(3mm, 2mm, 2mm), size=(8.66mm, 8.66mm, 0.4mm))
  Box88.move(11.34mm, 4.4408921e-16mm, 0mm)
  Box88.move(0mm, 10.66mm, 0mm)
  Box88.move(0mm, 32.66mm, 0mm)
  Box88.move(0mm, 7.1054274e-15mm, 1.4mm)
  Box88.move(0mm, 10.86mm, 4.4408921e-16mm)
  Box88.move(-11.34mm, 0mm, 0mm)
  Box88.move(0mm, -10.86mm, 0mm)
  Box89 [silicon] = box(corner=(14.34mm, 45.32mm, 1mm), size=(8.66mm, 8.66mm, 1mm))
  Box89.move(-3.5527137e-15mm, 0mm, 1.4mm)
  Box89.move(0mm, 0mm, 1.4mm)
  Box89.move(0mm, 10.86mm, 1.7763568e-15mm)
  Box89.move(-11.34mm, 1.4210855e-14mm, -4.4408921e-16mm)
  Box89.move(0mm, -10.86mm, 0mm)
  Box90 [silicon] = box(corner=(3mm, 2mm, 2mm), size=(8.66mm, 8.66mm, 0.4mm))
  Box90.move(11.34mm, 4.4408921e-16mm, 0mm)
  Box90.move(0mm, 10.66mm, 0mm)
  Box90.move(0mm, 32.66mm, 0mm)
  Box90.move(0mm, 7.1054274e-15mm, 2.8mm)
  Box90.move(0mm, 10.86mm, 2.6645353e-15mm)
  Box90.move(-11.34mm, 0mm, -8.8817842e-16mm)
  Box90.move(0mm, -10.86mm, -8.8817842e-16mm)
  Box91 [silicon] = box(corner=(14.34mm, 45.32mm, 1mm), size=(8.66mm, 8.66mm, 1mm))
  Box91.move(-3.5527137e-15mm, 0mm, 1.4mm)
  Box91.move(0mm, 0mm, 1.4mm)
  Box91.move(0mm, 0mm, 1.4mm)
  Box91.move(0mm, 10.86mm, 3.5527137e-15mm)
  Box91.move(-11.34mm, 1.4210855e-14mm, -8.8817842e-16mm)
  Box91.move(0mm, -10.86mm, -8.8817842e-16mm)
  Substrate [Epoxy Resin-JSME] = box(corner=(0mm, 0mm, 0mm), size=(26mm, 66.64mm, 1mm))
  Part2 [copper] = imported_body(C:\Users\USER\Downloads\Chiplet inter\lid-gpu.stp)
  Part2.rotate(axis=Z, angle=90deg)
  Part2.move(0mm, -242mm, -1104mm)
  Part2.move(-0.1mm, 15.531497mm, 2.2833017mm)
  Part2.move(0.6mm, -1.4237711mm, 0.1mm)
  Part2.move(0.5mm, -0.2924578mm, 0.0075422044mm)
  Part2.move(0mm, 0.4mm, -0.0075422044mm)
  Part2.move(0mm, 0.4mm, 0mm)
  Part2.move(3.5527137e-15mm, 0mm, 0.1mm)
  Box92 [silicon_dioxide] = box(corner=(1mm, 23.32mm, 1mm), size=(11mm, 9mm, 0.4mm))
  Box93 [silicon_dioxide] = box(corner=(14mm, 23.32mm, 1mm), size=(11mm, 9mm, 0.4mm))
  Box94 [silicon_dioxide] = box(corner=(1mm, 34.32mm, 1mm), size=(11mm, 9mm, 0.4mm))
  Box95 [silicon_dioxide] = box(corner=(14mm, 34.32mm, 1mm), size=(11mm, 9mm, 0.4mm))
  Box96 [copper] = box(corner=(1mm, 23.32mm, 2.4mm), size=(11mm, 9mm, 0.1mm))
  Box97 [copper] = box(corner=(1mm, 34.32mm, 2.4mm), size=(11mm, 9mm, 0.1mm))
  Box98 [copper] = box(corner=(14mm, 34.32mm, 2.4mm), size=(11mm, 9mm, 0.1mm))
  Box99 [copper] = box(corner=(14mm, 23.32mm, 2.4mm), size=(11mm, 9mm, 0.1mm))
  ADDA_AD0205HX_K50_1 = component(ADDA_AD0205HX_K50, Type=Fan Unit=mm ModelAs=3D Shape=Circular MovePlane=XY Radius=10.536859mm HubRadius=6.4903846mm CaseSize=25mm CaseHeight=6.5mm CaseSide SheetID=43 BodyID=34 HubID=49 CaseID=6 FlowDirChoice=NormalPositive FlowType=Curve SwirlType=RPM SolidCaseMaterial=Al-Extruded SolidHubMaterial=Al-Extruded PassageMaterial=air DimUnits(m3_per_s, n_per_meter_sq) X(0, 0.00028748062, 0.00036893355, 0.00045038648, 0.00052465448, 0.00057256658, 0.000649225, 0.00070432958, 0.0008121318, 0.00091754126, 0.0009918069, 0.0012601232) Y(49.831021, 36.428174, 32.218376, 27.407037, 23.197238, 20.53385, 17.354927, 15.808516, 14.176101, 12.45778, 10.223923, 0) Pressure_Loss_Curve{DimUnits("", "")} IntakeTemp=AmbientTemp Swirl=14000 OperatingRPM=0 HubPower=0.74W Magnitude=1)
  ADDA_AD0205HX_K50_Case [Al-Extruded] = part_of(ADDA_AD0205HX_K50_1)
  ADDA_AD0205HX_K50_Passage [air] = part_of(ADDA_AD0205HX_K50_1)
  ADDA_AD0205HX_K50_Surface = part_of(ADDA_AD0205HX_K50_1)
  ADDA_AD0205HX_K50_Hub [Al-Extruded] = part_of(ADDA_AD0205HX_K50_1)
  ADDA_AD0205HX_K50_1.move(TranslateVectorX=14mm TranslateVectorY=34.32mm TranslateVectorZ=-4mm)
  ADDA_AD0205HX_K50_1.move(TranslateVectorX=0mm TranslateVectorY=0mm TranslateVectorZ=24mm)
  Heatsink1_1 = component(Heatsink1, Type=HeatSink Unit=mm MovePlane=XY FinType=Extruded FlowDirection=Length BaseLength=24.4mm BaseWidth=22.2mm BaseHeight=1.325mm OverallHeight=20mm FinCount=10 FinThickness=1mm FinOffsetOnLength=0mm FinOffsetOnWidth=0mm BaseId=6 PinIds(34, 62, 90, 118, 146, 174, 202, 230, 258, 286) BaseMaterial=Al-Extruded FinMaterial=Al-Extruded BaseSurfaceMaterial=Steel-oxidised-surface FinSurfaceMaterial=Steel-oxidised-surface)
  Heatsink1_Base, Heatsink1_Pin1..Heatsink1_Pin10 [Al-Extruded] = part_of(Heatsink1_1)
  Heatsink1_1.move(TranslateVectorX=14mm TranslateVectorY=34.32mm TranslateVectorZ=1.5mm)
  Heatsink1_1.move(TranslateVectorX=-1mm TranslateVectorY=-0.61715126mm TranslateVectorZ=1mm)
  Heatsink1_1.move(TranslateVectorX=-3.5527137e-15mm TranslateVectorY=-0.0028487379mm TranslateVectorZ=0.1mm)
  ADDA_AD0205HX_K50_1.move(TranslateVectorX=0mm TranslateVectorY=0mm TranslateVectorZ=3mm)
  Box100 [silicon] = box(corner=(3mm, 12.66mm, 1mm), size=(8.66mm, 8.66mm, 1mm))
  Box100.move(0.56907522mm, 0.16498974mm, 2mm)
  Box100.move(10.770925mm, -0.16498974mm, 0mm)
  Box100.move(-11.34mm, -6.9277917e-14mm, -5mm)
  Box100.move(0mm, 4.9737992e-14mm, 5mm)
  Box100.move(5.7731597e-15mm, -10.66mm, 0mm)
  Box100.move(0mm, 3.7303494e-14mm, -0.6mm)
  Box100.move(0mm, 10.66mm, 0mm)
  Box100.move(0mm, 3.5527137e-15mm, 1.4mm)
boundaries and excitations:
  Block1: Block Objects=[Box7, Box9, Box8, Box6] Block_Type=Solid Use_External_Conditions Use_Total_Power Heat_Transfer_Coefficient=10w_per_m2kel Temperature=AmbientTemp Total_Power=10W
  Opening1: Opening Faces=Region.face(+x) Temperature=AmbientTemp External_Rad._Temperature=AmbientRadTemp Inlet_Type=Velocity Static_Pressure=AmbientPressure X_Velocity=10m_per_sec Y_Velocity=0m_per_sec Z_Velocity=0m_per_sec
  Opening2: Opening Faces=Region.face(-x, +z, +y, -y, -z) Temperature=AmbientTemp External_Rad._Temperature=AmbientRadTemp Inlet_Type=Pressure Total_Pressure=AmbientPressure
  Block2: Block Objects=[Box51, Box100, Box47, Box5, Box55, Box53, Box2, Box24, Box60, Box58, Box56, Box3, Box67, Box65, Box62, Box4, Box73, Box11, Box71, Box69, Box85, Box83, Box13, Box81, Box79, Box77, Box75, Box12, Box91, Box87, Box89, Box10] Block_Type=Solid Use_Total_Power Total_Power=66mW
mesh:
  MeshRegions:  Global{MeshMethod=MesherHD ComputeGap MeshRegionResolution=2 MinGapX=1mm MinGapY=1mm MinGapZ=1mm Objects=Region FacetLevel=3 ProximitySizeFunction CurvatureSizeFunction OptimizePCBMesh}
  MeshOperations:
setups:
  Setup1: IcepakSteadyState Flow_Regime=Turbulent Turbulent_Model_Eqn=ZeroEquation Include_Temperature=true Include_Flow=true Include_Gravity Solution_Initialization_-_Turbulent_Kinetic_Energy=1m2_per_s2 Solution_Initialization_-_Turbulent_Dissipation_Rate=1m2_per_s3 Solution_Initialization_-_Specific_Dissipation_Rate=1diss_per_s Convergence_Criteria_-_Flow=0.001 Convergence_Criteria_-_Energy=1e-07 Convergence_Criteria_-_Turbulent_Kinetic_Energy=0.001 Convergence_Criteria_-_Turbulent_Dissipation_Rate=0.001 Convergence_Criteria_-_Specific_Dissipation_Rate=0.001 disabled Radiation_Model=Off Under-relaxation_-_Pressure=0.3 Under-relaxation_-_Momentum=0.7 Under-relaxation_-_Temperature=1 Under-relaxation_-_Turbulent_Kinetic_Energy=0.8 Under-relaxation_-_Turbulent_Dissipation_Rate=0.8 Under-relaxation_-_Specific_Dissipation_Rate=0.8 Discretization_Scheme_-_Pressure=Standard Discretization_Scheme_-_Momentum=First Discretization_Scheme_-_Temperature=First Discretization_Scheme_-_Turbulent_Kinetic_Energy=First Discretization_Scheme_-_Turbulent_Dissipation_Rate=First Discretization_Scheme_-_Specific_Dissipation_Rate=First Convergence_Criteria_-_Max_Iterations=100
  Setup2: IcepakSteadyState Flow_Regime=Turbulent Turbulent_Model_Eqn=ZeroEquation Include_Temperature=true Include_Flow=true Include_Gravity Solution_Initialization_-_Turbulent_Kinetic_Energy=1m2_per_s2 Solution_Initialization_-_Turbulent_Dissipation_Rate=1m2_per_s3 Solution_Initialization_-_Specific_Dissipation_Rate=1diss_per_s Convergence_Criteria_-_Flow=0.001 Convergence_Criteria_-_Energy=1e-07 Convergence_Criteria_-_Turbulent_Kinetic_Energy=0.001 Convergence_Criteria_-_Turbulent_Dissipation_Rate=0.001 Convergence_Criteria_-_Specific_Dissipation_Rate=0.001 disabled Radiation_Model=Off Under-relaxation_-_Pressure=0.3 Under-relaxation_-_Momentum=0.7 Under-relaxation_-_Temperature=1 Under-relaxation_-_Turbulent_Kinetic_Energy=0.8 Under-relaxation_-_Turbulent_Dissipation_Rate=0.8 Under-relaxation_-_Specific_Dissipation_Rate=0.8 Discretization_Scheme_-_Pressure=Standard Discretization_Scheme_-_Momentum=First Discretization_Scheme_-_Temperature=First Discretization_Scheme_-_Turbulent_Kinetic_Energy=First Discretization_Scheme_-_Turbulent_Dissipation_Rate=First Discretization_Scheme_-_Specific_Dissipation_Rate=First Convergence_Criteria_-_Max_Iterations=100
field plots:
  SurfTemperature1, SurfTemperature2: Temperature over Interposer on Setup1 : SteadyState
