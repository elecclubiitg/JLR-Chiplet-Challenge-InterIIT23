# Ansys Electronics Desktop project, version 2023.2
materials:
  Al-Extruded: thermal_conductivity=205 mass_density=2800 specific_heat=900 youngs_modulus=69000000000 poissons_ratio=0.33 thermal_expansion_coefficient=2.277e-06 thermal_material_type=Solid
  air: permittivity=1.0006 permeability=1.0000004 thermal_conductivity=0.0261 mass_density=1.1614 specific_heat=1005 thermal_expansion_coefficient=0.00333 thermal_material_type=Fluid diffusivity=2.88e-05 molecular_mass=0.028966 viscosity=1.84e-05 material_refractive_index=1.000293
  copper: permeability=0.999991 conductivity=58000000 thermal_conductivity=400 mass_density=8933 specific_heat=385 youngs_modulus=120000000000 poissons_ratio=0.38 thermal_expansion_coefficient=1.77e-05
  silicon: permittivity=11.9 thermal_conductivity=148 mass_density=2330 specific_heat=712 youngs_modulus=135000000000 poissons_ratio=0.25 thermal_expansion_coefficient=2.54e-06
  gallium_arsenide: permittivity=12.9 thermal_conductivity=46 mass_density=5320 specific_heat=350 youngs_modulus=85500000000 poissons_ratio=0.31 thermal_expansion_coefficient=6.86e-06
  silicon_dioxide: permittivity=4 thermal_conductivity=1.5 mass_density=2220 specific_heat=745 thermal_expansion_coefficient=4.5e-06
  Epoxy Resin-JSME: thermal_conductivity=0.3 mass_density=1850 specific_heat=1100 thermal_material_type=Solid
surface materials:
  Steel-oxidised-surface: surface_emissivity=0.8

design IcepakDesign1 (Icepak, SteadyState TemperatureAndFlow, model units mm)
options: Default_Fluid_Material=air Default_Solid_Material=Al-Extruded Default_Surface_Material=Steel-oxidised-surface AmbientTemperature=20cel AmbientPressure=0n_per_meter_sq AmbientRadiationTemperature=20cel Gravity_Vector_CS_ID=Global Gravity_Vector_Axis=Z Positive=false Altitude=0meter
geometry:
  Region [air] = region(percentage_offset=50 on all sides)
  Substrate [Epoxy Resin-JSME] = box(corner=(0mm, 0mm, 0mm), size=((44+4+10) mm, 180mm, 1mm))
  Interposer [silicon] = box(corner=(0mm, 0mm, 1mm), size=((44+4+10) mm, 180mm, 0.1mm))
  Ethernet [gallium_arsenide] = box(corner=((4.5+2+5) mm, (21+30) mm, 1.1mm), size=(35mm, 22mm, 0.2mm))
  CPU [gallium_arsenide] = box(corner=((4.5+2+5+2.5) mm, (21+23+30) mm, 1.1mm), size=(30mm, 30mm, 0.2mm))
  Accelerator [gallium_arsenide] = box(corner=((2+1+5) mm, (21+23+31+30) mm, 1.1mm), size=(42mm, 22mm, 0.2mm))
  Memory [silicon] = box(corner=((2+1 +16 +5) mm, (21+23+31+27+30+5) mm, 1.1mm), size=(8mm, 8mm, 1mm))
  Part1 [copper] = imported_body(C:\Users\USER\Downloads\Chiplet inter\lid_app1.stp)
  Part1.rotate(axis=Z, angle=90deg)
  Part1.move(51mm, 48.464813mm, -1.6436884mm)
  Part1.move(1.4210855e-14mm, 0mm, 1.8mm)
  Heatsink1_1 = component(Heatsink1, Type=HeatSink Unit=mm MovePlane=XY FinType=Extruded FlowDirection=Length BaseLength=44mm BaseWidth=80mm BaseHeight=2mm OverallHeight=30mm FinCount=20 FinThickness=3mm FinOffsetOnLength=0mm FinOffsetOnWidth=0mm BaseId=6 PinIds(34, 62, 90, 118, 146, 174, 202, 230, 258, 286, 314, 342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) BaseMaterial=Al-Extruded FinMaterial=Al-Extruded BaseSurfaceMaterial=Steel-oxidised-surface FinSurfaceMaterial=Steel-oxidised-surface)
  Heatsink1_Base, Heatsink1_Pin1..Heatsink1_Pin20 [Al-Extruded] = part_of(Heatsink1_1)
  Heatsink1_1.move(TranslateVectorX=29mm TranslateVectorY=89mm TranslateVectorZ=2.8mm)
  Heatsink1_1.move(TranslateVectorX=0mm TranslateVectorY=0mm TranslateVectorZ=2mm)
  Heatsink1_1.move(TranslateVectorX=0mm TranslateVectorY=0mm TranslateVectorZ=-0.9mm)
  ADDA_AA8381HB_AT1 = component(ADDA_AA8381HB_AT, Type=Fan Unit=mm ModelAs=3D Shape=Circular MovePlane=XY Radius=38.285714mm HubRadius=25.714286mm CaseSize=80mm CaseHeight=38mm CaseSide SheetID=43 BodyID=34 HubID=49 CaseID=6 FlowDirChoice=NormalPositive FlowType=Curve SwirlType=RPM SolidCaseMaterial=Al-Extruded SolidHubMaterial=Al-Extruded PassageMaterial=air DimUnits(m3_per_s, n_per_meter_sq) X(0, 0.00089785161, 0.0014964178, 0.0025784421, 0.0035453633, 0.0043281022, 0.0050647979, 0.0059166158, 0.0070907265, 0.0086562232, 0.009300809, 0.0098763488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) Y(41.323458, 36.605479, 32.972017, 26.898268, 21.692114, 18.167113, 15.726827, 14.154134, 13.17798, 12.527211, 13.17798, 13.828749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) Pressure_Loss_Curve{DimUnits("", "")} IntakeTemp=AmbientTemp Swirl=2800 OperatingRPM=0 HubPower=7.8W Magnitude=1)
  ADDA_AA8381HB_AT_Case [Al-Extruded] = part_of(ADDA_AA8381HB_AT1)
  ADDA_AA8381HB_AT_Passage [air] = part_of(ADDA_AA8381HB_AT1)
  ADDA_AA8381HB_AT_Surface = part_of(ADDA_AA8381HB_AT1)
  ADDA_AA8381HB_AT_Hub [Al-Extruded] = part_of(ADDA_AA8381HB_AT1)
  ADDA_AA8381HB_AT1.move(TranslateVectorX=29mm TranslateVectorY=88.473684mm TranslateVectorZ=-4.1mm)
  ADDA_AA8381HB_AT1.move(TranslateVectorX=-18mm TranslateVectorY=0mm TranslateVectorZ=38mm)
  ADDA_AA8381HB_AT1.move(TranslateVectorX=19mm TranslateVectorY=1mm TranslateVectorZ=0.1mm)
  Ethernet1 [gallium_arsenide] = box(corner=((4.5+2+5) mm, (21+30) mm, 1.1mm), size=(35mm, 22mm, 1mm))
  CPU1 [gallium_arsenide] = box(corner=((4.5+2+5+2.5) mm, (21+23+30) mm, 1.1mm), size=(30mm, 30mm, 1mm))
  Accelerator1 [gallium_arsenide] = box(corner=((2+1+5) mm, (21+23+31+30) mm, 1.1mm), size=(42mm, 22mm, 1mm))
  Ethernet2 [silicon_dioxide] = box(corner=((4.5+2+5) mm, (21+30) mm, 1.1mm), size=(35mm, 22mm, 0.2mm))
  CPU2 [silicon_dioxide] = box(corner=((4.5+2+5+2.5) mm, (21+23+30) mm, 1.1mm), size=(30mm, 30mm, 0.2mm))
  Accelerator2 [silicon_dioxide] = box(corner=((2+1+5) mm, (21+23+31+30) mm, 1.1mm), size=(42mm, 22mm, 0.2mm))
  [Ethernet2, CPU2, Accelerator2].move(7.1054274e-15mm, 0mm, 1.2mm)
  [Accelerator1, CPU1, Ethernet1].move(7.1054274e-15mm, 0mm, 0.2mm)
boundaries and excitations:
  Block5: Block Objects=Memory Block_Type=Solid Use_Total_Power Total_Power=0.66W
  Opening3: Opening Faces=Region.face(+z, +y, -y, -z) Temperature=AmbientTemp External_Rad._Temperature=AmbientRadTemp Inlet_Type=Pressure Total_Pressure=AmbientPressure
  Opening4: Opening Faces=Region.face(+x) Temperature=AmbientTemp External_Rad._Temperature=AmbientRadTemp Inlet_Type=Pressure Total_Pressure=AmbientPressure
  Block6: Block Objects=CPU1 Block_Type=Solid Use_Total_Power Total_Power=12W
  Block7: Block Objects=Ethernet1 Block_Type=Solid Use_Total_Power Total_Power=1.5W
  Block8: Block Objects=Accelerator1 Block_Type=Solid Use_Total_Power Total_Power=2.5W
mesh:
  MeshRegions:  Global{MeshMethod=MesherHD ComputeGap MeshRegionResolution=4 MinGapX=1mm MinGapY=1mm MinGapZ=1mm Objects=Region FacetLevel=3 ProximitySizeFunction CurvatureSizeFunction OptimizePCBMesh}
  MeshOperations:
setups:
  Setup1: IcepakSteadyState Flow_Regime=Turbulent Turbulent_Model_Eqn=ZeroEquation Include_Temperature=true Include_Flow=true Include_Gravity Solution_Initialization_-_Turbulent_Kinetic_Energy=1m2_per_s2 Solution_Initialization_-_Turbulent_Dissipation_Rate=1m2_per_s3 Solution_Initialization_-_Specific_Dissipation_Rate=1diss_per_s Convergence_Criteria_-_Flow=0.001 Convergence_Criteria_-_Energy=1e-07 Convergence_Criteria_-_Turbulent_Kinetic_Energy=0.001 Convergence_Criteria_-_Turbulent_Dissipation_Rate=0.001 Convergence_Criteria_-_Specific_Dissipation_Rate=0.001 disabled Radiation_Model=Off Under-relaxation_-_Pressure=0.3 Under-relaxation_-_Momentum=0.7 Under-relaxation_-_Temperature=1 Under-relaxation_-_Turbulent_Kinetic_Energy=0.8 Under-relaxation_-_Turbulent_Dissipation_Rate=0.8 Under-relaxation_-_Specific_Dissipation_Rate=0.8 Discretization_Scheme_-_Pressure=Standard Discretization_Scheme_-_Momentum=First Discretization_Scheme_-_Temperature=First Discretization_Scheme_-_Turbulent_Kinetic_Energy=First Discretization_Scheme_-_Turbulent_Dissipation_Rate=First Discretization_Scheme_-_Specific_Dissipation_Rate=First Convergence_Criteria_-_Max_Iterations=100
field plots:
  SurfTemperature1: Temperature over Interposer on Setup1 : SteadyState
